`include "disciplines.vams"

module delay_t3(in1, ou1);
  electrical in1, ou1;
  input in1;
  output ou1;
  parameter real t3 = 71.43e-12 from (0:inf); //since 14gb/s gives 71.43 ps for a bit
  analog begin
    V(ou1) <+ absdelay(V(in1), t3);
  end
endmodule

module mult_1(in1, in2, ou1);
  electrical in1, in2, ou1;
  input in1, in2;
  output ou1;
  real vout;
  analog begin
    if (V(in1) <= 0 && V(in2) <= 0) //assumes 0 input voltage is "low"
      vout = -0.3;
    else if (V(in1) <= 0 && V(in2) > 0)
      vout = 0.3;
    else if (V(in1) > 0 && V(in2) <= 0)
      vout = 0.3;
    else
      vout = -0.3;
    V(ou1) <+ vout;
  end
endmodule

module mult_2(in1, in2, ou1);
  electrical in1, in2, ou1;
  input in1, in2;
  output ou1;
  parameter real vmid = 0 from [0:inf);
  analog begin
    V(ou1) <+ V(in1)*(V(in2)-vmid);
  end
endmodule

module vi_converter(in1, ou1, gnd);
  electrical in1, ou1, gnd;
  inout gnd;
  input in1;
  output ou1;
  parameter real g = 1m from (0:inf);
  analog begin
    I(gnd, ou1) <+ V(in1)*g;
  end
endmodule

module capacitor(in1, ou1);
  electrical in1, ou1;
  inout in1, ou1;
  parameter real c = 1p from (0:inf);
  analog begin
    I(in1, ou1) <+ c*ddt(V(in1, ou1));
  end
endmodule

module pi_control(in1, ou1);
  electrical in1, ou1;
  input in1;
  output ou1;
  parameter real vmax = 0.7 from (0:inf);
  real m;
  analog begin
    m = V(in1)/vmax;
    V(ou1) <+ m;
  end
endmodule

module pi(in1, in2, ou1); // in1 is clock, in2 is setting m
  electrical in1, in2, ou1;
  input in1, in2;
  output ou1;
  parameter real dmax = 142.86e-12 from (0:inf);
  real d;
  analog begin
    d = min(max(V(in2), 0.01), 1.0) * dmax;
    V(ou1) <+ absdelay(V(in1), d, dmax); //shifter now has a minimum delay of about 1.4 ps instead of 0 since zero delay in absdelay stalls ngspice
  end
endmodule

module buffer(in1, ou1);
  electrical in1, ou1;
  input in1;
  output ou1;
  analog begin
    V(ou1) <+ V(in1);
  end
endmodule

//top level
module phase_aligner(cml_dff_x4, clk7_cml2cmos, ck_28);
  electrical cml_dff_x4, clk7_cml2cmos, ck_28;
  electrical t3_ou, m1_ou, m2_ou, vi_ou, pi_ctrl_ou, pi_ou, gnd;
  ground gnd;
  input clk7_cml2cmos, cml_dff_x4;
  output ck_28;
  delay_t3     #(.t3(71.43e-12))    d_t3    (.in1(cml_dff_x4), .ou1(t3_ou));
  mult_1                            m_1     (.in1(cml_dff_x4), .in2(t3_ou), .ou1(m1_ou));
  mult_2       #(.vmid(0.35))       m_2     (.in1(m1_ou), .in2(ck_28), .ou1(m2_ou));
  vi_converter #(.g(1m))            vi      (.in1(m2_ou), .ou1(vi_ou), .gnd(gnd));
  capacitor                         cap     (.in1(vi_ou), .ou1(gnd));
  pi_control   #(.vmax(0.7))        pi_ctrl (.in1(vi_ou), .ou1(pi_ctrl_ou));
  pi           #(.dmax(142.86e-12)) pi1     (.in1(clk7_cml2cmos), .in2(pi_ctrl_ou), .ou1(pi_ou));
  buffer                            buff1   (.in1(pi_ou), .ou1(ck_28));
endmodule
